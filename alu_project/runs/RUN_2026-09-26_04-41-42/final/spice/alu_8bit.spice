* NGSPICE file created from alu_8bit.ext - technology: sky130A

* Black-box entry subcircuit for sky130_fd_sc_hd__fill_1 abstract view
.subckt sky130_fd_sc_hd__fill_1 VGND VNB VPB VPWR
.ends

* Black-box entry subcircuit for sky130_fd_sc_hd__decap_3 abstract view
.subckt sky130_fd_sc_hd__decap_3 VGND VNB VPB VPWR
.ends

* Black-box entry subcircuit for sky130_fd_sc_hd__nor2_2 abstract view
.subckt sky130_fd_sc_hd__nor2_2 A B VGND VNB VPB VPWR Y
.ends

* Black-box entry subcircuit for sky130_fd_sc_hd__and2_2 abstract view
.subckt sky130_fd_sc_hd__and2_2 A B VGND VNB VPB VPWR X
.ends

* Black-box entry subcircuit for sky130_fd_sc_hd__buf_2 abstract view
.subckt sky130_fd_sc_hd__buf_2 A VGND VNB VPB VPWR X
.ends

* Black-box entry subcircuit for sky130_fd_sc_hd__buf_8 abstract view
.subckt sky130_fd_sc_hd__buf_8 A VGND VNB VPB VPWR X
.ends

* Black-box entry subcircuit for sky130_fd_sc_hd__tapvpwrvgnd_1 abstract view
.subckt sky130_fd_sc_hd__tapvpwrvgnd_1 VGND VPWR
.ends

* Black-box entry subcircuit for sky130_fd_sc_hd__inv_2 abstract view
.subckt sky130_fd_sc_hd__inv_2 A VGND VNB VPB VPWR Y
.ends

* Black-box entry subcircuit for sky130_fd_sc_hd__o22a_2 abstract view
.subckt sky130_fd_sc_hd__o22a_2 A1 A2 B1 B2 VGND VNB VPB VPWR X
.ends

* Black-box entry subcircuit for sky130_fd_sc_hd__clkdlybuf4s25_1 abstract view
.subckt sky130_fd_sc_hd__clkdlybuf4s25_1 A VGND VNB VPB VPWR X
.ends

* Black-box entry subcircuit for sky130_fd_sc_hd__a31o_2 abstract view
.subckt sky130_fd_sc_hd__a31o_2 A1 A2 A3 B1 VGND VNB VPB VPWR X
.ends

* Black-box entry subcircuit for sky130_fd_sc_hd__xor2_2 abstract view
.subckt sky130_fd_sc_hd__xor2_2 A B VGND VNB VPB VPWR X
.ends

* Black-box entry subcircuit for sky130_fd_sc_hd__a211o_2 abstract view
.subckt sky130_fd_sc_hd__a211o_2 A1 A2 B1 C1 VGND VNB VPB VPWR X
.ends

* Black-box entry subcircuit for sky130_fd_sc_hd__fill_2 abstract view
.subckt sky130_fd_sc_hd__fill_2 VGND VNB VPB VPWR
.ends

* Black-box entry subcircuit for sky130_fd_sc_hd__nand3_2 abstract view
.subckt sky130_fd_sc_hd__nand3_2 A B C VGND VNB VPB VPWR Y
.ends

* Black-box entry subcircuit for sky130_fd_sc_hd__o21ai_2 abstract view
.subckt sky130_fd_sc_hd__o21ai_2 A1 A2 B1 VGND VNB VPB VPWR Y
.ends

* Black-box entry subcircuit for sky130_fd_sc_hd__dlymetal6s2s_1 abstract view
.subckt sky130_fd_sc_hd__dlymetal6s2s_1 A VGND VNB VPB VPWR X
.ends

* Black-box entry subcircuit for sky130_fd_sc_hd__a21o_2 abstract view
.subckt sky130_fd_sc_hd__a21o_2 A1 A2 B1 VGND VNB VPB VPWR X
.ends

* Black-box entry subcircuit for sky130_fd_sc_hd__o2bb2a_2 abstract view
.subckt sky130_fd_sc_hd__o2bb2a_2 A1_N A2_N B1 B2 VGND VNB VPB VPWR X
.ends

* Black-box entry subcircuit for sky130_fd_sc_hd__or3b_4 abstract view
.subckt sky130_fd_sc_hd__or3b_4 A B C_N VGND VNB VPB VPWR X
.ends

* Black-box entry subcircuit for sky130_fd_sc_hd__o221a_2 abstract view
.subckt sky130_fd_sc_hd__o221a_2 A1 A2 B1 B2 C1 VGND VNB VPB VPWR X
.ends

* Black-box entry subcircuit for sky130_fd_sc_hd__buf_6 abstract view
.subckt sky130_fd_sc_hd__buf_6 A VGND VNB VPB VPWR X
.ends

* Black-box entry subcircuit for sky130_fd_sc_hd__xnor2_2 abstract view
.subckt sky130_fd_sc_hd__xnor2_2 A B VGND VNB VPB VPWR Y
.ends

* Black-box entry subcircuit for sky130_fd_sc_hd__nand2_2 abstract view
.subckt sky130_fd_sc_hd__nand2_2 A B VGND VNB VPB VPWR Y
.ends

* Black-box entry subcircuit for sky130_fd_sc_hd__a31oi_2 abstract view
.subckt sky130_fd_sc_hd__a31oi_2 A1 A2 A3 B1 VGND VNB VPB VPWR Y
.ends

* Black-box entry subcircuit for sky130_fd_sc_hd__or3_2 abstract view
.subckt sky130_fd_sc_hd__or3_2 A B C VGND VNB VPB VPWR X
.ends

* Black-box entry subcircuit for sky130_fd_sc_hd__a221oi_2 abstract view
.subckt sky130_fd_sc_hd__a221oi_2 A1 A2 B1 B2 C1 VGND VNB VPB VPWR Y
.ends

* Black-box entry subcircuit for sky130_fd_sc_hd__a21oi_2 abstract view
.subckt sky130_fd_sc_hd__a21oi_2 A1 A2 B1 VGND VNB VPB VPWR Y
.ends

* Black-box entry subcircuit for sky130_fd_sc_hd__and3_4 abstract view
.subckt sky130_fd_sc_hd__and3_4 A B C VGND VNB VPB VPWR X
.ends

* Black-box entry subcircuit for sky130_fd_sc_hd__o32a_2 abstract view
.subckt sky130_fd_sc_hd__o32a_2 A1 A2 A3 B1 B2 VGND VNB VPB VPWR X
.ends

* Black-box entry subcircuit for sky130_fd_sc_hd__a2111o_2 abstract view
.subckt sky130_fd_sc_hd__a2111o_2 A1 A2 B1 C1 D1 VGND VNB VPB VPWR X
.ends

* Black-box entry subcircuit for sky130_fd_sc_hd__o21a_4 abstract view
.subckt sky130_fd_sc_hd__o21a_4 A1 A2 B1 VGND VNB VPB VPWR X
.ends

* Black-box entry subcircuit for sky130_fd_sc_hd__a2bb2o_2 abstract view
.subckt sky130_fd_sc_hd__a2bb2o_2 A1_N A2_N B1 B2 VGND VNB VPB VPWR X
.ends

* Black-box entry subcircuit for sky130_fd_sc_hd__a31o_4 abstract view
.subckt sky130_fd_sc_hd__a31o_4 A1 A2 A3 B1 VGND VNB VPB VPWR X
.ends

* Black-box entry subcircuit for sky130_fd_sc_hd__or4b_4 abstract view
.subckt sky130_fd_sc_hd__or4b_4 A B C D_N VGND VNB VPB VPWR X
.ends

* Black-box entry subcircuit for sky130_fd_sc_hd__and2b_2 abstract view
.subckt sky130_fd_sc_hd__and2b_2 A_N B VGND VNB VPB VPWR X
.ends

* Black-box entry subcircuit for sky130_fd_sc_hd__a21o_4 abstract view
.subckt sky130_fd_sc_hd__a21o_4 A1 A2 B1 VGND VNB VPB VPWR X
.ends

* Black-box entry subcircuit for sky130_fd_sc_hd__a21boi_2 abstract view
.subckt sky130_fd_sc_hd__a21boi_2 A1 A2 B1_N VGND VNB VPB VPWR Y
.ends

* Black-box entry subcircuit for sky130_fd_sc_hd__nand2b_2 abstract view
.subckt sky130_fd_sc_hd__nand2b_2 A_N B VGND VNB VPB VPWR Y
.ends

* Black-box entry subcircuit for sky130_fd_sc_hd__a311o_2 abstract view
.subckt sky130_fd_sc_hd__a311o_2 A1 A2 A3 B1 C1 VGND VNB VPB VPWR X
.ends

* Black-box entry subcircuit for sky130_fd_sc_hd__a211oi_2 abstract view
.subckt sky130_fd_sc_hd__a211oi_2 A1 A2 B1 C1 VGND VNB VPB VPWR Y
.ends

* Black-box entry subcircuit for sky130_fd_sc_hd__o31a_2 abstract view
.subckt sky130_fd_sc_hd__o31a_2 A1 A2 A3 B1 VGND VNB VPB VPWR X
.ends

* Black-box entry subcircuit for sky130_fd_sc_hd__clkbuf_2 abstract view
.subckt sky130_fd_sc_hd__clkbuf_2 A VGND VNB VPB VPWR X
.ends

* Black-box entry subcircuit for sky130_fd_sc_hd__o21a_2 abstract view
.subckt sky130_fd_sc_hd__o21a_2 A1 A2 B1 VGND VNB VPB VPWR X
.ends

* Black-box entry subcircuit for sky130_fd_sc_hd__or2_2 abstract view
.subckt sky130_fd_sc_hd__or2_2 A B VGND VNB VPB VPWR X
.ends

* Black-box entry subcircuit for sky130_fd_sc_hd__nand3b_2 abstract view
.subckt sky130_fd_sc_hd__nand3b_2 A_N B C VGND VNB VPB VPWR Y
.ends

* Black-box entry subcircuit for sky130_fd_sc_hd__o211a_2 abstract view
.subckt sky130_fd_sc_hd__o211a_2 A1 A2 B1 C1 VGND VNB VPB VPWR X
.ends

* Black-box entry subcircuit for sky130_fd_sc_hd__and3b_2 abstract view
.subckt sky130_fd_sc_hd__and3b_2 A_N B C VGND VNB VPB VPWR X
.ends

.subckt alu_8bit VGND VPWR a[0] a[1] a[2] a[3] a[4] a[5] a[6] a[7] b[0] b[1] b[2]
+ b[3] b[4] b[5] b[6] b[7] opcode[0] opcode[1] opcode[2] overflow result[0] result[1]
+ result[2] result[3] result[4] result[5] result[6] result[7] zero
XFILLER_12_65 VGND VGND VPWR VPWR sky130_fd_sc_hd__fill_1
XFILLER_3_12 VGND VGND VPWR VPWR sky130_fd_sc_hd__decap_3
XFILLER_0_68 VGND VGND VPWR VPWR sky130_fd_sc_hd__decap_3
XFILLER_9_88 VGND VGND VPWR VPWR sky130_fd_sc_hd__decap_3
X_131_ _135_/B _138_/B VGND VGND VPWR VPWR _131_/Y sky130_fd_sc_hd__nor2_2
X_114_ _114_/A _114_/B VGND VGND VPWR VPWR _115_/B sky130_fd_sc_hd__and2_2
Xrebuffer39 _116_/B VGND VGND VPWR VPWR _111_/B sky130_fd_sc_hd__buf_2
XFILLER_15_21 VGND VGND VPWR VPWR sky130_fd_sc_hd__decap_3
XFILLER_15_65 VGND VGND VPWR VPWR sky130_fd_sc_hd__decap_3
XFILLER_3_24 VGND VGND VPWR VPWR sky130_fd_sc_hd__decap_3
Xoutput20 _146_/X VGND VGND VPWR VPWR overflow sky130_fd_sc_hd__buf_8
XFILLER_12_88 VGND VGND VPWR VPWR sky130_fd_sc_hd__decap_3
XPHY_EDGE_ROW_12_Right_12 VGND VGND VPWR VPWR sky130_fd_sc_hd__decap_3
XTAP_TAPCELL_ROW_8_45 VGND VPWR sky130_fd_sc_hd__tapvpwrvgnd_1
X_130_ _130_/A VGND VGND VPWR VPWR _140_/A sky130_fd_sc_hd__inv_2
XFILLER_9_12 VGND VGND VPWR VPWR sky130_fd_sc_hd__fill_1
X_113_ _123_/A _123_/B _114_/B _114_/A VGND VGND VPWR VPWR _113_/X sky130_fd_sc_hd__o22a_2
XFILLER_15_77 VGND VGND VPWR VPWR sky130_fd_sc_hd__decap_3
XFILLER_15_88 VGND VGND VPWR VPWR sky130_fd_sc_hd__decap_3
XPHY_EDGE_ROW_6_Right_6 VGND VGND VPWR VPWR sky130_fd_sc_hd__decap_3
XTAP_TAPCELL_ROW_2_36 VGND VPWR sky130_fd_sc_hd__tapvpwrvgnd_1
Xoutput21 _191_/A VGND VGND VPWR VPWR result[0] sky130_fd_sc_hd__clkdlybuf4s25_1
XFILLER_12_56 VGND VGND VPWR VPWR sky130_fd_sc_hd__decap_3
XFILLER_3_3 VGND VGND VPWR VPWR sky130_fd_sc_hd__fill_1
XFILLER_9_57 VGND VGND VPWR VPWR sky130_fd_sc_hd__decap_3
XTAP_TAPCELL_ROW_8_46 VGND VPWR sky130_fd_sc_hd__tapvpwrvgnd_1
X_189_ _132_/Y _184_/X _185_/Y _188_/X VGND VGND VPWR VPWR _190_/B sky130_fd_sc_hd__a31o_2
XFILLER_6_47 VGND VGND VPWR VPWR sky130_fd_sc_hd__fill_1
X_112_ _114_/A _114_/B VGND VGND VPWR VPWR _115_/A sky130_fd_sc_hd__nor2_2
XTAP_TAPCELL_ROW_15_56 VGND VPWR sky130_fd_sc_hd__tapvpwrvgnd_1
XTAP_TAPCELL_ROW_2_37 VGND VPWR sky130_fd_sc_hd__tapvpwrvgnd_1
Xoutput22 _191_/B VGND VGND VPWR VPWR result[1] sky130_fd_sc_hd__clkdlybuf4s25_1
XPHY_EDGE_ROW_12_Left_28 VGND VGND VPWR VPWR sky130_fd_sc_hd__decap_3
X_111_ _111_/A _111_/B VGND VGND VPWR VPWR _114_/B sky130_fd_sc_hd__xor2_2
X_188_ _136_/X _183_/A _186_/X _187_/Y VGND VGND VPWR VPWR _188_/X sky130_fd_sc_hd__a211o_2
XFILLER_10_90 VGND VGND VPWR VPWR sky130_fd_sc_hd__fill_1
XFILLER_15_24 VGND VGND VPWR VPWR sky130_fd_sc_hd__decap_3
XFILLER_15_68 VGND VGND VPWR VPWR sky130_fd_sc_hd__fill_1
XFILLER_6_59 VGND VGND VPWR VPWR sky130_fd_sc_hd__decap_3
XTAP_TAPCELL_ROW_15_57 VGND VPWR sky130_fd_sc_hd__tapvpwrvgnd_1
Xoutput23 _191_/C VGND VGND VPWR VPWR result[2] sky130_fd_sc_hd__clkdlybuf4s25_1
XFILLER_3_27 VGND VGND VPWR VPWR sky130_fd_sc_hd__fill_1
XPHY_EDGE_ROW_15_Left_31 VGND VGND VPWR VPWR sky130_fd_sc_hd__decap_3
XFILLER_12_47 VGND VGND VPWR VPWR sky130_fd_sc_hd__fill_1
XFILLER_13_90 VGND VGND VPWR VPWR sky130_fd_sc_hd__fill_1
XFILLER_9_26 VGND VGND VPWR VPWR sky130_fd_sc_hd__fill_2
XPHY_EDGE_ROW_0_Left_16 VGND VGND VPWR VPWR sky130_fd_sc_hd__decap_3
X_187_ _187_/A _187_/B VGND VGND VPWR VPWR _187_/Y sky130_fd_sc_hd__nor2_2
X_110_ _110_/A _110_/B VGND VGND VPWR VPWR _123_/B sky130_fd_sc_hd__xor2_2
XTAP_TAPCELL_ROW_15_58 VGND VPWR sky130_fd_sc_hd__tapvpwrvgnd_1
Xoutput24 _167_/X VGND VGND VPWR VPWR result[3] sky130_fd_sc_hd__clkdlybuf4s25_1
XFILLER_12_59 VGND VGND VPWR VPWR sky130_fd_sc_hd__decap_3
XFILLER_0_29 VGND VGND VPWR VPWR sky130_fd_sc_hd__decap_3
X_186_ _133_/B _187_/A _098_/A _181_/B VGND VGND VPWR VPWR _186_/X sky130_fd_sc_hd__a31o_2
XFILLER_1_72 VGND VGND VPWR VPWR sky130_fd_sc_hd__decap_3
X_169_ _169_/A _169_/B VGND VGND VPWR VPWR _169_/Y sky130_fd_sc_hd__nor2_2
Xoutput25 _172_/X VGND VGND VPWR VPWR result[4] sky130_fd_sc_hd__clkdlybuf4s25_1
XFILLER_12_27 VGND VGND VPWR VPWR sky130_fd_sc_hd__fill_1
XFILLER_4_50 VGND VGND VPWR VPWR sky130_fd_sc_hd__decap_3
X_185_ _185_/A _185_/B _185_/C VGND VGND VPWR VPWR _185_/Y sky130_fd_sc_hd__nand3_2
X_099_ _181_/A _182_/B VGND VGND VPWR VPWR _099_/Y sky130_fd_sc_hd__nor2_2
X_168_ _126_/A _126_/B _132_/Y VGND VGND VPWR VPWR _169_/B sky130_fd_sc_hd__o21ai_2
XFILLER_15_27 VGND VGND VPWR VPWR sky130_fd_sc_hd__fill_1
XFILLER_6_29 VGND VGND VPWR VPWR sky130_fd_sc_hd__fill_1
XPHY_EDGE_ROW_1_Right_1 VGND VGND VPWR VPWR sky130_fd_sc_hd__decap_3
Xoutput26 _180_/X VGND VGND VPWR VPWR result[5] sky130_fd_sc_hd__dlymetal6s2s_1
X_184_ _185_/A _185_/B _185_/C VGND VGND VPWR VPWR _184_/X sky130_fd_sc_hd__a21o_2
XPHY_EDGE_ROW_7_Left_23 VGND VGND VPWR VPWR sky130_fd_sc_hd__decap_3
X_098_ _098_/A _129_/A VGND VGND VPWR VPWR _182_/B sky130_fd_sc_hd__xor2_2
X_167_ _166_/X _164_/X _173_/B _093_/A VGND VGND VPWR VPWR _167_/X sky130_fd_sc_hd__o2bb2a_2
XPHY_EDGE_ROW_15_Right_15 VGND VGND VPWR VPWR sky130_fd_sc_hd__decap_3
Xoutput27 _190_/X VGND VGND VPWR VPWR result[6] sky130_fd_sc_hd__dlymetal6s2s_1
XFILLER_4_85 VGND VGND VPWR VPWR sky130_fd_sc_hd__decap_3
X_097_ _097_/A _138_/C _138_/B VGND VGND VPWR VPWR _097_/X sky130_fd_sc_hd__or3b_4
X_183_ _183_/A VGND VGND VPWR VPWR _185_/C sky130_fd_sc_hd__inv_2
X_166_ _093_/A _187_/B _163_/Y _124_/A _165_/Y VGND VGND VPWR VPWR _166_/X sky130_fd_sc_hd__o221a_2
XFILLER_15_29 VGND VGND VPWR VPWR sky130_fd_sc_hd__decap_3
Xoutput28 _144_/X VGND VGND VPWR VPWR result[7] sky130_fd_sc_hd__buf_6
X_149_ _149_/A _187_/B VGND VGND VPWR VPWR _149_/Y sky130_fd_sc_hd__nor2_2
XFILLER_7_52 VGND VGND VPWR VPWR sky130_fd_sc_hd__decap_3
XFILLER_13_84 VGND VGND VPWR VPWR sky130_fd_sc_hd__decap_3
XFILLER_4_42 VGND VGND VPWR VPWR sky130_fd_sc_hd__fill_1
XFILLER_4_53 VGND VGND VPWR VPWR sky130_fd_sc_hd__decap_3
XTAP_TAPCELL_ROW_0_32 VGND VPWR sky130_fd_sc_hd__tapvpwrvgnd_1
X_182_ _187_/A _182_/B VGND VGND VPWR VPWR _183_/A sky130_fd_sc_hd__xnor2_2
XTAP_TAPCELL_ROW_6_42 VGND VPWR sky130_fd_sc_hd__tapvpwrvgnd_1
X_096_ _138_/C _133_/B VGND VGND VPWR VPWR _173_/B sky130_fd_sc_hd__nand2_2
X_165_ _133_/B _093_/A _110_/A _181_/B VGND VGND VPWR VPWR _165_/Y sky130_fd_sc_hd__a31oi_2
X_148_ _119_/A _149_/A _135_/X _147_/Y VGND VGND VPWR VPWR _148_/X sky130_fd_sc_hd__o22a_2
XPHY_EDGE_ROW_5_Right_5 VGND VGND VPWR VPWR sky130_fd_sc_hd__decap_3
Xoutput29 _193_/Y VGND VGND VPWR VPWR zero sky130_fd_sc_hd__buf_6
XFILLER_4_65 VGND VGND VPWR VPWR sky130_fd_sc_hd__fill_1
XFILLER_1_66 VGND VGND VPWR VPWR sky130_fd_sc_hd__decap_3
XFILLER_1_88 VGND VGND VPWR VPWR sky130_fd_sc_hd__decap_3
XTAP_TAPCELL_ROW_0_33 VGND VPWR sky130_fd_sc_hd__tapvpwrvgnd_1
X_095_ _138_/C _135_/B VGND VGND VPWR VPWR _181_/B sky130_fd_sc_hd__and2_2
Xfanout31 input18/X VGND VGND VPWR VPWR _097_/A sky130_fd_sc_hd__buf_6
X_181_ _181_/A _181_/B VGND VGND VPWR VPWR _190_/A sky130_fd_sc_hd__nand2_2
X_164_ _164_/A _164_/B _164_/C VGND VGND VPWR VPWR _164_/X sky130_fd_sc_hd__or3_2
XTAP_TAPCELL_ROW_6_43 VGND VPWR sky130_fd_sc_hd__tapvpwrvgnd_1
X_147_ _138_/C _138_/B _119_/A _149_/A _135_/B VGND VGND VPWR VPWR _147_/Y sky130_fd_sc_hd__a221oi_2
XPHY_EDGE_ROW_11_Right_11 VGND VGND VPWR VPWR sky130_fd_sc_hd__decap_3
XFILLER_13_64 VGND VGND VPWR VPWR sky130_fd_sc_hd__fill_2
XFILLER_4_88 VGND VGND VPWR VPWR sky130_fd_sc_hd__decap_3
XTAP_TAPCELL_ROW_0_34 VGND VPWR sky130_fd_sc_hd__tapvpwrvgnd_1
XTAP_TAPCELL_ROW_13_53 VGND VPWR sky130_fd_sc_hd__tapvpwrvgnd_1
Xfanout32 input18/X VGND VGND VPWR VPWR _133_/B sky130_fd_sc_hd__clkdlybuf4s25_1
X_180_ _180_/A _180_/B VGND VGND VPWR VPWR _180_/X sky130_fd_sc_hd__and2_2
X_094_ _094_/A VGND VGND VPWR VPWR _114_/A sky130_fd_sc_hd__inv_2
X_163_ _132_/Y _164_/C _136_/X VGND VGND VPWR VPWR _163_/Y sky130_fd_sc_hd__a21oi_2
XFILLER_7_55 VGND VGND VPWR VPWR sky130_fd_sc_hd__fill_1
XPHY_EDGE_ROW_11_Left_27 VGND VGND VPWR VPWR sky130_fd_sc_hd__decap_3
X_129_ _129_/A _129_/B VGND VGND VPWR VPWR _130_/A sky130_fd_sc_hd__xnor2_2
X_146_ _146_/A _146_/B _146_/C VGND VGND VPWR VPWR _146_/X sky130_fd_sc_hd__and3_4
XFILLER_4_56 VGND VGND VPWR VPWR sky130_fd_sc_hd__decap_3
XPHY_EDGE_ROW_14_Left_30 VGND VGND VPWR VPWR sky130_fd_sc_hd__decap_3
XFILLER_13_43 VGND VGND VPWR VPWR sky130_fd_sc_hd__fill_1
XFILLER_13_87 VGND VGND VPWR VPWR sky130_fd_sc_hd__decap_3
X_093_ _093_/A VGND VGND VPWR VPWR _123_/A sky130_fd_sc_hd__inv_2
X_162_ _115_/Y _162_/A2 _115_/A VGND VGND VPWR VPWR _164_/C sky130_fd_sc_hd__a21oi_2
XFILLER_10_55 VGND VGND VPWR VPWR sky130_fd_sc_hd__decap_3
XFILLER_1_24 VGND VGND VPWR VPWR sky130_fd_sc_hd__decap_3
XFILLER_1_57 VGND VGND VPWR VPWR sky130_fd_sc_hd__fill_1
Xinput1 a[0] VGND VGND VPWR VPWR _149_/A sky130_fd_sc_hd__clkdlybuf4s25_1
X_145_ _142_/X _173_/B _143_/A VGND VGND VPWR VPWR _146_/C sky130_fd_sc_hd__a21o_2
XFILLER_7_67 VGND VGND VPWR VPWR sky130_fd_sc_hd__decap_3
XPHY_EDGE_ROW_9_Right_9 VGND VGND VPWR VPWR sky130_fd_sc_hd__decap_3
X_128_ _143_/A _128_/B VGND VGND VPWR VPWR _129_/B sky130_fd_sc_hd__xnor2_2
Xmax_cap30 _097_/X VGND VGND VPWR VPWR _116_/B sky130_fd_sc_hd__buf_8
XFILLER_13_55 VGND VGND VPWR VPWR sky130_fd_sc_hd__fill_1
XFILLER_10_12 VGND VGND VPWR VPWR sky130_fd_sc_hd__fill_1
XFILLER_1_69 VGND VGND VPWR VPWR sky130_fd_sc_hd__decap_3
X_092_ _187_/A VGND VGND VPWR VPWR _181_/A sky130_fd_sc_hd__inv_2
Xinput2 a[1] VGND VGND VPWR VPWR _118_/B sky130_fd_sc_hd__clkdlybuf4s25_1
X_161_ _158_/X _159_/X _160_/X _173_/B _094_/A VGND VGND VPWR VPWR _191_/C sky130_fd_sc_hd__o32a_2
X_127_ _126_/B _126_/A _099_/Y _174_/B _109_/A VGND VGND VPWR VPWR _141_/B sky130_fd_sc_hd__a2111o_2
X_144_ _143_/A _173_/B _142_/X VGND VGND VPWR VPWR _144_/X sky130_fd_sc_hd__o21a_4
XFILLER_4_47 VGND VGND VPWR VPWR sky130_fd_sc_hd__decap_3
Xinput3 a[2] VGND VGND VPWR VPWR _094_/A sky130_fd_sc_hd__clkdlybuf4s25_1
X_160_ _094_/A _187_/B _136_/X _115_/Y VGND VGND VPWR VPWR _160_/X sky130_fd_sc_hd__a2bb2o_2
X_143_ _143_/A _143_/B VGND VGND VPWR VPWR _146_/B sky130_fd_sc_hd__nand2_2
XPHY_EDGE_ROW_0_Right_0 VGND VGND VPWR VPWR sky130_fd_sc_hd__decap_3
X_126_ _126_/A _126_/B VGND VGND VPWR VPWR _169_/A sky130_fd_sc_hd__and2_2
XFILLER_4_26 VGND VGND VPWR VPWR sky130_fd_sc_hd__fill_2
X_109_ _109_/A _109_/B VGND VGND VPWR VPWR _126_/A sky130_fd_sc_hd__nor2_2
XFILLER_1_27 VGND VGND VPWR VPWR sky130_fd_sc_hd__fill_2
XFILLER_6_3 VGND VGND VPWR VPWR sky130_fd_sc_hd__decap_3
XPHY_EDGE_ROW_3_Left_19 VGND VGND VPWR VPWR sky130_fd_sc_hd__decap_3
XTAP_TAPCELL_ROW_9_47 VGND VPWR sky130_fd_sc_hd__tapvpwrvgnd_1
Xinput4 a[3] VGND VGND VPWR VPWR _093_/A sky130_fd_sc_hd__clkdlybuf4s25_1
XFILLER_10_25 VGND VGND VPWR VPWR sky130_fd_sc_hd__decap_3
XFILLER_10_36 VGND VGND VPWR VPWR sky130_fd_sc_hd__fill_1
XFILLER_10_58 VGND VGND VPWR VPWR sky130_fd_sc_hd__fill_1
XPHY_EDGE_ROW_6_Left_22 VGND VGND VPWR VPWR sky130_fd_sc_hd__decap_3
X_125_ _115_/Y _164_/A _121_/X _122_/Y VGND VGND VPWR VPWR _126_/B sky130_fd_sc_hd__a31o_4
X_142_ _142_/A _142_/B _142_/C _134_/X VGND VGND VPWR VPWR _142_/X sky130_fd_sc_hd__or4b_4
XTAP_TAPCELL_ROW_3_38 VGND VPWR sky130_fd_sc_hd__tapvpwrvgnd_1
X_108_ _107_/B _108_/B VGND VGND VPWR VPWR _109_/B sky130_fd_sc_hd__and2b_2
XFILLER_5_81 VGND VGND VPWR VPWR sky130_fd_sc_hd__fill_2
XTAP_TAPCELL_ROW_10_48 VGND VPWR sky130_fd_sc_hd__tapvpwrvgnd_1
Xinput5 a[4] VGND VGND VPWR VPWR _107_/B sky130_fd_sc_hd__clkdlybuf4s25_1
X_141_ _141_/A _141_/B _146_/A VGND VGND VPWR VPWR _142_/B sky130_fd_sc_hd__and3_4
XFILLER_2_82 VGND VGND VPWR VPWR sky130_fd_sc_hd__fill_2
XFILLER_7_49 VGND VGND VPWR VPWR sky130_fd_sc_hd__decap_3
X_124_ _124_/A VGND VGND VPWR VPWR _164_/A sky130_fd_sc_hd__inv_2
XFILLER_8_81 VGND VGND VPWR VPWR sky130_fd_sc_hd__decap_3
X_107_ _108_/B _107_/B VGND VGND VPWR VPWR _109_/A sky130_fd_sc_hd__and2b_2
XPHY_EDGE_ROW_14_Right_14 VGND VGND VPWR VPWR sky130_fd_sc_hd__decap_3
XTAP_TAPCELL_ROW_10_49 VGND VPWR sky130_fd_sc_hd__tapvpwrvgnd_1
Xinput6 a[5] VGND VGND VPWR VPWR _173_/A sky130_fd_sc_hd__clkdlybuf4s25_1
X_140_ _140_/A _164_/B VGND VGND VPWR VPWR _146_/A sky130_fd_sc_hd__nor2_2
XFILLER_8_71 VGND VGND VPWR VPWR sky130_fd_sc_hd__fill_1
XPHY_EDGE_ROW_4_Right_4 VGND VGND VPWR VPWR sky130_fd_sc_hd__decap_3
X_106_ _106_/A _110_/B VGND VGND VPWR VPWR _108_/B sky130_fd_sc_hd__xor2_2
X_123_ _123_/A _123_/B VGND VGND VPWR VPWR _124_/A sky130_fd_sc_hd__xnor2_2
XFILLER_14_81 VGND VGND VPWR VPWR sky130_fd_sc_hd__decap_3
Xinput7 a[6] VGND VGND VPWR VPWR _187_/A sky130_fd_sc_hd__clkdlybuf4s25_1
X_122_ _123_/A _123_/B _113_/X VGND VGND VPWR VPWR _122_/Y sky130_fd_sc_hd__a21oi_2
Xinput10 b[1] VGND VGND VPWR VPWR _116_/A sky130_fd_sc_hd__clkdlybuf4s25_1
XTAP_TAPCELL_ROW_4_40 VGND VPWR sky130_fd_sc_hd__tapvpwrvgnd_1
X_105_ _174_/B VGND VGND VPWR VPWR _185_/A sky130_fd_sc_hd__inv_2
XFILLER_13_28 VGND VGND VPWR VPWR sky130_fd_sc_hd__fill_2
XFILLER_2_85 VGND VGND VPWR VPWR sky130_fd_sc_hd__decap_3
XTAP_TAPCELL_ROW_11_50 VGND VPWR sky130_fd_sc_hd__tapvpwrvgnd_1
Xinput8 a[7] VGND VGND VPWR VPWR _143_/A sky130_fd_sc_hd__clkdlybuf4s25_1
XFILLER_11_50 VGND VGND VPWR VPWR sky130_fd_sc_hd__decap_3
XPHY_EDGE_ROW_10_Left_26 VGND VGND VPWR VPWR sky130_fd_sc_hd__decap_3
X_104_ _101_/B _173_/A VGND VGND VPWR VPWR _174_/B sky130_fd_sc_hd__and2b_2
X_121_ _118_/Y _120_/Y _117_/X VGND VGND VPWR VPWR _121_/X sky130_fd_sc_hd__a21o_4
Xinput11 b[2] VGND VGND VPWR VPWR _111_/A sky130_fd_sc_hd__clkdlybuf4s25_1
XFILLER_5_41 VGND VGND VPWR VPWR sky130_fd_sc_hd__fill_2
Xinput9 b[0] VGND VGND VPWR VPWR _119_/A sky130_fd_sc_hd__clkdlybuf4s25_1
XFILLER_2_64 VGND VGND VPWR VPWR sky130_fd_sc_hd__fill_2
XPHY_EDGE_ROW_10_Right_10 VGND VGND VPWR VPWR sky130_fd_sc_hd__decap_3
X_120_ _119_/A _111_/B _119_/Y VGND VGND VPWR VPWR _120_/Y sky130_fd_sc_hd__o21ai_2
Xinput12 b[3] VGND VGND VPWR VPWR _110_/A sky130_fd_sc_hd__clkdlybuf4s25_1
XFILLER_8_85 VGND VGND VPWR VPWR sky130_fd_sc_hd__decap_3
X_103_ _181_/A _182_/B _102_/Y VGND VGND VPWR VPWR _141_/A sky130_fd_sc_hd__a21boi_2
XFILLER_5_53 VGND VGND VPWR VPWR sky130_fd_sc_hd__decap_3
XPHY_EDGE_ROW_8_Right_8 VGND VGND VPWR VPWR sky130_fd_sc_hd__decap_3
XFILLER_14_62 VGND VGND VPWR VPWR sky130_fd_sc_hd__fill_1
X_102_ _099_/Y _174_/A VGND VGND VPWR VPWR _102_/Y sky130_fd_sc_hd__nand2b_2
Xinput13 b[4] VGND VGND VPWR VPWR _106_/A sky130_fd_sc_hd__clkdlybuf4s25_1
X_179_ _185_/B _176_/X _178_/X VGND VGND VPWR VPWR _180_/B sky130_fd_sc_hd__a21o_2
XFILLER_8_42 VGND VGND VPWR VPWR sky130_fd_sc_hd__fill_2
XFILLER_14_85 VGND VGND VPWR VPWR sky130_fd_sc_hd__decap_3
XFILLER_11_53 VGND VGND VPWR VPWR sky130_fd_sc_hd__decap_3
XFILLER_2_11 VGND VGND VPWR VPWR sky130_fd_sc_hd__fill_2
XFILLER_2_88 VGND VGND VPWR VPWR sky130_fd_sc_hd__decap_3
Xinput14 b[5] VGND VGND VPWR VPWR _100_/A sky130_fd_sc_hd__clkdlybuf4s25_1
X_101_ _173_/A _101_/B VGND VGND VPWR VPWR _174_/A sky130_fd_sc_hd__and2b_2
X_178_ _133_/B _173_/A _100_/A _181_/B _177_/X VGND VGND VPWR VPWR _178_/X sky130_fd_sc_hd__a311o_2
XPHY_EDGE_ROW_2_Left_18 VGND VGND VPWR VPWR sky130_fd_sc_hd__decap_3
XFILLER_11_43 VGND VGND VPWR VPWR sky130_fd_sc_hd__decap_3
XTAP_TAPCELL_ROW_7_44 VGND VPWR sky130_fd_sc_hd__tapvpwrvgnd_1
X_100_ _100_/A _129_/A VGND VGND VPWR VPWR _101_/B sky130_fd_sc_hd__xor2_2
Xinput15 b[6] VGND VGND VPWR VPWR _098_/A sky130_fd_sc_hd__clkdlybuf4s25_1
X_177_ _173_/A _187_/B _174_/Y _136_/X VGND VGND VPWR VPWR _177_/X sky130_fd_sc_hd__a2bb2o_2
XFILLER_8_88 VGND VGND VPWR VPWR sky130_fd_sc_hd__decap_3
XPHY_EDGE_ROW_5_Left_21 VGND VGND VPWR VPWR sky130_fd_sc_hd__decap_3
XTAP_TAPCELL_ROW_14_54 VGND VPWR sky130_fd_sc_hd__tapvpwrvgnd_1
XTAP_TAPCELL_ROW_1_35 VGND VPWR sky130_fd_sc_hd__tapvpwrvgnd_1
X_193_ _190_/A _190_/B _144_/X _192_/X VGND VGND VPWR VPWR _193_/Y sky130_fd_sc_hd__a211oi_2
Xinput16 b[7] VGND VGND VPWR VPWR _128_/B sky130_fd_sc_hd__clkdlybuf4s25_1
X_176_ _109_/A _169_/A _174_/Y _132_/Y VGND VGND VPWR VPWR _176_/X sky130_fd_sc_hd__o31a_2
X_159_ _135_/B _094_/A _111_/A _181_/B VGND VGND VPWR VPWR _159_/X sky130_fd_sc_hd__a31o_2
XFILLER_5_35 VGND VGND VPWR VPWR sky130_fd_sc_hd__decap_3
XFILLER_14_88 VGND VGND VPWR VPWR sky130_fd_sc_hd__decap_3
XTAP_TAPCELL_ROW_14_55 VGND VPWR sky130_fd_sc_hd__tapvpwrvgnd_1
X_192_ _180_/A _180_/B _167_/X _172_/X _191_/X VGND VGND VPWR VPWR _192_/X sky130_fd_sc_hd__a2111o_2
XFILLER_11_67 VGND VGND VPWR VPWR sky130_fd_sc_hd__fill_2
Xinput17 opcode[0] VGND VGND VPWR VPWR _138_/B sky130_fd_sc_hd__clkbuf_2
X_175_ _109_/A _169_/A _174_/Y VGND VGND VPWR VPWR _185_/B sky130_fd_sc_hd__o21ai_2
XFILLER_8_68 VGND VGND VPWR VPWR sky130_fd_sc_hd__decap_3
X_158_ _115_/Y _121_/X _157_/Y VGND VGND VPWR VPWR _158_/X sky130_fd_sc_hd__o21a_2
XFILLER_0_80 VGND VGND VPWR VPWR sky130_fd_sc_hd__decap_3
XPHY_EDGE_ROW_3_Right_3 VGND VGND VPWR VPWR sky130_fd_sc_hd__decap_3
XFILLER_11_46 VGND VGND VPWR VPWR sky130_fd_sc_hd__fill_1
X_191_ _191_/A _191_/B _191_/C VGND VGND VPWR VPWR _191_/X sky130_fd_sc_hd__or3_2
XFILLER_8_36 VGND VGND VPWR VPWR sky130_fd_sc_hd__fill_2
Xinput18 opcode[1] VGND VGND VPWR VPWR input18/X sky130_fd_sc_hd__buf_6
X_174_ _174_/A _174_/B VGND VGND VPWR VPWR _174_/Y sky130_fd_sc_hd__nor2_2
X_157_ _115_/Y _121_/X _164_/B VGND VGND VPWR VPWR _157_/Y sky130_fd_sc_hd__a21oi_2
XFILLER_5_26 VGND VGND VPWR VPWR sky130_fd_sc_hd__decap_3
XPHY_EDGE_ROW_9_Left_25 VGND VGND VPWR VPWR sky130_fd_sc_hd__decap_3
XFILLER_14_24 VGND VGND VPWR VPWR sky130_fd_sc_hd__decap_3
XPHY_EDGE_ROW_13_Right_13 VGND VGND VPWR VPWR sky130_fd_sc_hd__decap_3
XFILLER_2_27 VGND VGND VPWR VPWR sky130_fd_sc_hd__fill_1
Xinput19 opcode[2] VGND VGND VPWR VPWR _138_/C sky130_fd_sc_hd__clkbuf_2
X_190_ _190_/A _190_/B VGND VGND VPWR VPWR _190_/X sky130_fd_sc_hd__and2_2
X_173_ _173_/A _173_/B VGND VGND VPWR VPWR _180_/A sky130_fd_sc_hd__or2_2
XFILLER_8_48 VGND VGND VPWR VPWR sky130_fd_sc_hd__fill_2
X_156_ _156_/A _156_/B _156_/C VGND VGND VPWR VPWR _191_/B sky130_fd_sc_hd__or3_2
XFILLER_0_71 VGND VGND VPWR VPWR sky130_fd_sc_hd__decap_3
XFILLER_5_38 VGND VGND VPWR VPWR sky130_fd_sc_hd__decap_3
X_139_ _143_/A _187_/B _136_/X _140_/A VGND VGND VPWR VPWR _142_/C sky130_fd_sc_hd__a2bb2o_2
XFILLER_11_15 VGND VGND VPWR VPWR sky130_fd_sc_hd__fill_1
XFILLER_12_80 VGND VGND VPWR VPWR sky130_fd_sc_hd__decap_3
XFILLER_3_71 VGND VGND VPWR VPWR sky130_fd_sc_hd__fill_2
XFILLER_3_82 VGND VGND VPWR VPWR sky130_fd_sc_hd__fill_1
X_172_ _169_/Y _170_/X _171_/X _173_/B _107_/B VGND VGND VPWR VPWR _172_/X sky130_fd_sc_hd__o32a_2
X_155_ _118_/B _187_/B _136_/X _118_/Y VGND VGND VPWR VPWR _156_/C sky130_fd_sc_hd__a2bb2o_2
XFILLER_0_83 VGND VGND VPWR VPWR sky130_fd_sc_hd__fill_1
XTAP_TAPCELL_ROW_4_39 VGND VPWR sky130_fd_sc_hd__tapvpwrvgnd_1
X_138_ _135_/B _138_/B _138_/C VGND VGND VPWR VPWR _187_/B sky130_fd_sc_hd__nand3b_2
XFILLER_14_59 VGND VGND VPWR VPWR sky130_fd_sc_hd__decap_3
XPHY_EDGE_ROW_7_Right_7 VGND VGND VPWR VPWR sky130_fd_sc_hd__decap_3
XFILLER_15_80 VGND VGND VPWR VPWR sky130_fd_sc_hd__decap_3
X_171_ _107_/B _187_/B _136_/X _126_/A VGND VGND VPWR VPWR _171_/X sky130_fd_sc_hd__a2bb2o_2
X_154_ _138_/C _116_/A _118_/B _135_/B VGND VGND VPWR VPWR _156_/B sky130_fd_sc_hd__o211a_2
XFILLER_0_62 VGND VGND VPWR VPWR sky130_fd_sc_hd__decap_3
X_137_ _135_/B _143_/A _128_/B _181_/B VGND VGND VPWR VPWR _142_/A sky130_fd_sc_hd__a31o_2
XFILLER_14_27 VGND VGND VPWR VPWR sky130_fd_sc_hd__fill_1
Xrebuffer33 _097_/X VGND VGND VPWR VPWR _129_/A sky130_fd_sc_hd__buf_2
X_170_ _133_/B _107_/B _106_/A _181_/B VGND VGND VPWR VPWR _170_/X sky130_fd_sc_hd__a31o_2
XFILLER_0_74 VGND VGND VPWR VPWR sky130_fd_sc_hd__decap_3
XFILLER_0_85 VGND VGND VPWR VPWR sky130_fd_sc_hd__decap_3
XPHY_EDGE_ROW_13_Left_29 VGND VGND VPWR VPWR sky130_fd_sc_hd__decap_3
X_136_ _138_/C _131_/Y _135_/X VGND VGND VPWR VPWR _136_/X sky130_fd_sc_hd__a21o_2
X_153_ _118_/Y _120_/Y _152_/Y VGND VGND VPWR VPWR _156_/A sky130_fd_sc_hd__o21a_2
X_119_ _119_/A _149_/A VGND VGND VPWR VPWR _119_/Y sky130_fd_sc_hd__nand2_2
XFILLER_6_62 VGND VGND VPWR VPWR sky130_fd_sc_hd__fill_2
XPHY_EDGE_ROW_1_Left_17 VGND VGND VPWR VPWR sky130_fd_sc_hd__decap_3
Xrebuffer34 _097_/A VGND VGND VPWR VPWR _135_/B sky130_fd_sc_hd__buf_2
XFILLER_12_83 VGND VGND VPWR VPWR sky130_fd_sc_hd__fill_1
X_152_ _118_/Y _120_/Y _164_/B VGND VGND VPWR VPWR _152_/Y sky130_fd_sc_hd__a21oi_2
XFILLER_9_51 VGND VGND VPWR VPWR sky130_fd_sc_hd__decap_3
XFILLER_9_73 VGND VGND VPWR VPWR sky130_fd_sc_hd__decap_3
XPHY_EDGE_ROW_4_Left_20 VGND VGND VPWR VPWR sky130_fd_sc_hd__decap_3
XTAP_TAPCELL_ROW_5_41 VGND VPWR sky130_fd_sc_hd__tapvpwrvgnd_1
X_118_ _118_/A _118_/B VGND VGND VPWR VPWR _118_/Y sky130_fd_sc_hd__xnor2_2
X_135_ _138_/C _135_/B _138_/B VGND VGND VPWR VPWR _135_/X sky130_fd_sc_hd__and3b_2
XFILLER_14_29 VGND VGND VPWR VPWR sky130_fd_sc_hd__fill_2
XFILLER_15_50 VGND VGND VPWR VPWR sky130_fd_sc_hd__decap_3
XFILLER_6_85 VGND VGND VPWR VPWR sky130_fd_sc_hd__decap_3
Xrebuffer35 _116_/B VGND VGND VPWR VPWR _110_/B sky130_fd_sc_hd__buf_2
XFILLER_15_83 VGND VGND VPWR VPWR sky130_fd_sc_hd__fill_1
XFILLER_0_32 VGND VGND VPWR VPWR sky130_fd_sc_hd__decap_3
XFILLER_0_65 VGND VGND VPWR VPWR sky130_fd_sc_hd__decap_3
XFILLER_12_62 VGND VGND VPWR VPWR sky130_fd_sc_hd__decap_3
XTAP_TAPCELL_ROW_12_51 VGND VPWR sky130_fd_sc_hd__tapvpwrvgnd_1
X_134_ _141_/A _134_/A2 _130_/A _164_/B VGND VGND VPWR VPWR _134_/X sky130_fd_sc_hd__a211o_2
X_151_ _148_/X _149_/Y _150_/X _173_/B _149_/A VGND VGND VPWR VPWR _191_/A sky130_fd_sc_hd__o32a_2
XFILLER_9_85 VGND VGND VPWR VPWR sky130_fd_sc_hd__decap_3
X_117_ _118_/A _118_/B VGND VGND VPWR VPWR _117_/X sky130_fd_sc_hd__and2b_2
Xrebuffer36 _142_/X VGND VGND VPWR VPWR _143_/B sky130_fd_sc_hd__buf_6
XFILLER_12_85 VGND VGND VPWR VPWR sky130_fd_sc_hd__decap_3
XTAP_TAPCELL_ROW_12_52 VGND VPWR sky130_fd_sc_hd__tapvpwrvgnd_1
X_150_ _135_/B _119_/A _149_/A _181_/B VGND VGND VPWR VPWR _150_/X sky130_fd_sc_hd__a31o_2
XFILLER_0_77 VGND VGND VPWR VPWR sky130_fd_sc_hd__decap_3
XFILLER_0_88 VGND VGND VPWR VPWR sky130_fd_sc_hd__decap_3
X_133_ _138_/C _133_/B VGND VGND VPWR VPWR _164_/B sky130_fd_sc_hd__or2_2
XPHY_EDGE_ROW_2_Right_2 VGND VGND VPWR VPWR sky130_fd_sc_hd__decap_3
X_116_ _116_/A _116_/B VGND VGND VPWR VPWR _118_/A sky130_fd_sc_hd__xor2_2
Xrebuffer37 _141_/B VGND VGND VPWR VPWR _134_/A2 sky130_fd_sc_hd__buf_2
XFILLER_15_85 VGND VGND VPWR VPWR sky130_fd_sc_hd__decap_3
XFILLER_12_53 VGND VGND VPWR VPWR sky130_fd_sc_hd__decap_3
X_132_ _138_/C _133_/B VGND VGND VPWR VPWR _132_/Y sky130_fd_sc_hd__nor2_2
XFILLER_9_43 VGND VGND VPWR VPWR sky130_fd_sc_hd__fill_1
XFILLER_9_54 VGND VGND VPWR VPWR sky130_fd_sc_hd__fill_2
XPHY_EDGE_ROW_8_Left_24 VGND VGND VPWR VPWR sky130_fd_sc_hd__decap_3
X_115_ _115_/A _115_/B VGND VGND VPWR VPWR _115_/Y sky130_fd_sc_hd__nor2_2
XFILLER_15_53 VGND VGND VPWR VPWR sky130_fd_sc_hd__decap_3
XFILLER_6_44 VGND VGND VPWR VPWR sky130_fd_sc_hd__decap_3
XFILLER_6_88 VGND VGND VPWR VPWR sky130_fd_sc_hd__decap_3
Xrebuffer38 _121_/X VGND VGND VPWR VPWR _162_/A2 sky130_fd_sc_hd__buf_2
.ends
